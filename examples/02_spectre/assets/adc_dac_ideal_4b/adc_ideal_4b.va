`include "constants.vams"
`include "disciplines.vams"
`default_transition 30p

// Ideal 4-bit clocked ADC.
// Samples vin on each rising edge of clk → 4-bit binary code on dout[3:0].
// vstep = V(vdd,vss)/16; codes 0..15.

module adc_ideal_4b (
    input  electrical        vin,
    input  electrical        clk,
    input  electrical        vdd,
    input  electrical        vss,
    input  electrical        rst_n,
    output electrical [3:0]  dout
);

    integer code;
    real    vstep, v_in, v_supply, vth;
    real    dout0_target, dout1_target, dout2_target, dout3_target;

    analog begin
        @(initial_step)
            $strobe("[adc_ideal_4b] INIT | vdd_vss=%.3gV", V(vdd, vss));

        v_supply = V(vdd, vss);
        vth      = (V(vdd) + V(vss)) / 2.0;
        vstep    = v_supply / 16.0;

        // Sample on rising clock edge
        @(cross(V(clk, vss) - vth, +1)) begin
            if (V(rst_n, vss) < vth) begin
                code = 0;
            end else begin
                v_in = V(vin, vss);
                code = v_in / vstep;
                if (code <  0) code =  0;
                if (code > 15) code = 15;
            end
            $strobe("\n[adc_ideal_4b] t=%.3f ns | vin=%g | code=%d", $abstime*1e9, v_in, code);
        end

        dout0_target = V(vss);
        dout1_target = V(vss);
        dout2_target = V(vss);
        dout3_target = V(vss);

        if ((code >> 0) & 1) dout0_target = V(vdd);
        if ((code >> 1) & 1) dout1_target = V(vdd);
        if ((code >> 2) & 1) dout2_target = V(vdd);
        if ((code >> 3) & 1) dout3_target = V(vdd);

        V(dout[0]) <+ transition(dout0_target);
        V(dout[1]) <+ transition(dout1_target);
        V(dout[2]) <+ transition(dout2_target);
        V(dout[3]) <+ transition(dout3_target);
    end

endmodule
